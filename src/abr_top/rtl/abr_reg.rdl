// SPDX-License-Identifier: Apache-2.0
//
// Licensed under the Apache License, Version 2.0 (the "License");
// you may not use this file except in compliance with the License.
// You may obtain a copy of the License at
//
// http://www.apache.org/licenses/LICENSE-2.0
//
// Unless required by applicable law or agreed to in writing, software
// distributed under the License is distributed on an "AS IS" BASIS,
// WITHOUT WARRANTIES OR CONDITIONS OF ANY KIND, either express or implied.
// See the License for the specific language governing permissions and
// limitations under the License.
//

addrmap abr_reg {
    desc="address maps for adams bridge register space";


    addressing = regalign; // This is the default if not specified
    lsb0 = true; // lsb0 property is implicit/default. See docs for
                 // SystemRDL 2.0 sections 9.1 and 13.4

    default hw = na;
    signal {activelow; async; cpuif_reset; field_reset;} reset_b;
    signal {activelow; async;} hard_reset_b;
    signal {} abr_ready;


    /* -----------------------
    * Register definitive definitions
    * ----------------------- */

    /* ---- MLDSA Component Name ---- */
    reg {
        name = "MLDSA component name register type definition";
        desc = "Two 32-bit read-only registers representing of the name
                of MLDSA component.";

        default sw = r;
        default hw = w;
        field {desc = "Name field";} NAME[32];

    } MLDSA_NAME[2];



    /* ---- MLDSA Component Version ---- */
    reg {
        name = "MLDSA component version register type definition";
        desc = "Two 32-bit read-only registers representing of the version
                of MLDSA component.";

        default sw = r;
        default hw = w;
        field {desc = "Version field";} VERSION[32];
        
    } MLDSA_VERSION[2];



    /* ---- MLDSA Component Control ---- */
    reg {
        name = "MLDSA component control register type definition";
        desc = "Control register to set the type of MLDSA operations.";

        default sw = w;
        default hw = r;
        default resetsignal = reset_b;
        field {desc = "Control command field. This can be: 
                [br]            000 for NONE
                [br]            001 for KEYGEN
                [br]            010 for SIGNING
                [br]            011 for VERIFYING
                [br]            100 for KEYGEN+SIGN
                
                [br] After each software write, hardware will erase the register"; swwe = abr_ready; hwclr;} CTRL[3] = 3'b0;
        field {desc = "Zeroize all internal registers: Zeroize all internal registers and memories to avoid SCA leakage.
                                [br] Software write generates only a single-cycle pulse on the 
                                hardware interface and then will be erased"; singlepulse;} ZEROIZE = 1'b0;
        field {desc = "Run PCR Signing flow: Run MLDSA KeyGen+Signing flow to sign PCRs."; swwe = abr_ready; hwclr;} PCR_SIGN = 1'b0;
        field {desc = "ExternalMu Mode"; swwe = abr_ready; hwclr;} EXTERNAL_MU = 1'b0;
        field {desc = "Enable streaming mode to get message for signing/verifying operation"; swwe = abr_ready; hwclr;} STREAM_MSG = 1'b0;
    
    } MLDSA_CTRL;

    /* ---- MLDSA Component Status ---- */
    reg {
        name = "MLDSA component status register type definition";
        desc = "One 5-bit register including the following flags: 
                [br]bit #0: READY : ​Indicates if the core is ready to take
                [br]                a control command and process the inputs.  
                [br]bit #1: VALID : ​Indicates if the process is done and the
                [br]                result is valid. 
                [br]bit #2: MSG_STREAM_READY: Indicates if the core is ready 
                [br]                          to recieve the message in streaming mode.
                [br]bit #3: ERROR: Indicates the process ended with an error
                [br]bit #4: VERIFY_PASS: Indicates that the last completed MLDSA
                [br]                     VERIFY operation passed. Hardware performs
                [br]                     the full c~ comparison internally, so this
                [br]                     bit alone is the authoritative signature
                [br]                     verification result. Hardware clears it when
                [br]                     a VERIFY starts and when a VERIFY aborts
                [br]                     early on a rejected signature, so it never
                [br]                     carries a previous verdict forward.
                [br]                     Firmware may additionally
                [br]                     compare MLDSA_VERIFY_RES against its own copy
                [br]                     of c to detect fault attacks on this bit.
                ";

        default sw = r;
        default hw = w;
        default resetsignal = reset_b;
        field {desc = "Status ready bit";} READY = 1'b0;
        field {hw = rw; desc = "Status valid bit";} VALID = 1'b0;
        field {desc = "The core is ready to recieve the message in streaming mode";} MSG_STREAM_READY = 1'b0;
        field {hw = rw; desc = "Status error bit";} ERROR = 1'b0;
        field {desc = "Signature verification result.  ";} VERIFY_PASS = 1'b0;
    
    } MLDSA_STATUS;


    /* ---- ABR Component Input ENTROPY ---- */
    reg {
        name = "ABR component entropy register type definition, used for MLDSA and MLKEM";
        desc = "16 32-bit registers storing the 512-bit entropy  
                required for SCA countermeasures with no change on the outputs. 
                The entropy can be any 512-bit value in [0 : 2^512-1].";

        default sw = w;
        default hw = r;
        default resetsignal = reset_b;
        field {desc = "Input entropy field"; swwe = abr_ready; hwclr;} ENTROPY[32] = 32'b0;
    
    } ABR_ENTROPY[16];

    /* ---- MLDSA Component Input SEED ---- */
    reg {
        name = "MLDSA component seed register type definition";
        desc = "8 32-bit registers storing the 256-bit seed for keygen.
                The seed can be any 256-bit value in [0 : 2^256-1].";

        default sw = w;
        default hw = rw;
        default we = true;
        default resetsignal = reset_b;
        field {desc = "Input seed field"; swwe; hwclr;} SEED[32] = 32'b0;
    
    } MLDSA_SEED[8];

    
    /* ---- MLDSA Component Input sign_rnd ---- */
    reg {
        name = "MLDSA component sign_rnd register type definition";
        desc = "8 32-bit registers storing the 256-bit sign_rnd for signing.
                The sign_rnd can be any 256-bit value in [0 : 2^256-1].
                sign_rnd should be all zero for deterministic variant.";

        default sw = w;
        default hw = r;
        default resetsignal = reset_b;
        field {desc = "Input sign_rnd field"; swwe = abr_ready; hwclr;} SIGN_RND[32] = 32'b0;
    
    } MLDSA_SIGN_RND[8];


    /* ---- MLDSA Component Input Message ---- */
    reg {
        name = "MLDSA component message register type definition";
        desc = "16 32-bit registers storing the message.
                The message can be a fixed size of 512-bit value in [0 : 2^512-1].";

        default sw = w;
        default hw = rw;
        default we = true;
        default resetsignal = reset_b;
        field {desc = "Input message field"; swmod; swwe; hwclr;} MSG[32] = 32'b0;
    
    } MLDSA_MSG[16];

    /* ---- MLDSA Component Verify Result ---- */
    reg {
        name = "MLDSA component verify result register type definition";
        desc = "16 32-bit registers storing the result of verifying operation.
                Hardware compares this value against the first part of the given
                signature, i.e. c~, and reports the result in
                MLDSA_STATUS.VERIFY_PASS. Firmware may independently compare this
                register against its own copy of c~ as a fault-attack check on
                MLDSA_STATUS.VERIFY_PASS. The comparison reference must be a
                firmware-held copy of c~ for that check to be independent.";

        default sw = r;
        default hw = rw;
        default we = true;
        default resetsignal = reset_b;
        field {desc = "Output verify result field"; hwclr;} VERIFY_RES[32] = 32'b0;
    
    } MLDSA_VERIFY_RES[16];

    /* ---- MLDSA Component Input EXTERNAL_MU ---- */
    reg {
        name = "MLDSA component external_mu register type definition";
        desc = "16 32-bit registers storing the external_mu.
                The external_mu can be any 512-bit value in [0 : 2^512-1].";

        default sw = w;
        default hw = rw;
        default we = true;
        default resetsignal = reset_b;
        field {desc = "Input externally computed mu field"; swwe = abr_ready; hwclr;} EXTERNAL_MU[32] = 32'b0;
    
    } MLDSA_EXTERNAL_MU[16];
    
    /* ---- MLDSA Component Input MSG_STROBE ---- */
    reg {
        name = "MLDSA component msg strobe register type definition";
        desc = "Byte enable strobe for each 32 bits of message.
                [br] Must be set to 4'b1111 before streaming message, after observing stream_msg_rdy.
                [br] Set to 1 for each valid byte in the last msg data, starting from LSB.
                [br] Valid values are 4'b0000, 4'b0001, 4'b0011, 4'b0111, and 4'b1111
                [br] A 32 bit aligned msg must write this to 4'h0 and write to msg input once.";

        default sw = w;
        default hw = r;
        default resetsignal = reset_b;
        field {desc = "Input message strobe"; swwe; hwclr;} STROBE[4] = 4'hF;
    
    } MLDSA_MSG_STROBE;
    
        /* ---- MLDSA Component Input Context Config ---- */
    reg {
        name = "MLDSA component Input Context Config register type definition";
        desc = "Registers defining the size of the context.
                The context is an optional byte-string.";

        default sw = w;
        default hw = r;
        default resetsignal = reset_b;
        field {desc = "Context Byte size field"; swwe = abr_ready; hwclr;} CTX_SIZE[8] = 8'b0;

    } MLDSA_CTX_CONFIG;

    /* ---- MLDSA Component Input Context ---- */
    reg {
        name = "MLDSA component context register type definition";
        desc = "up tp 255 bytes registers storing the context.";

        default sw = w;
        default hw = r;
        default resetsignal = reset_b;
        field {desc = "Input context field"; swwe = abr_ready; hwclr;} CTX[32] = 32'b0;

    } MLDSA_CTX[64];

    /* ---- MLDSA Component Public Key ---- */
    external mem {
        name = "MLDSA component public key register type definition";
        desc = "648 32-bit registers storing the public key. 
                These registers are read by MLDSA user after keygen operation, 
                or set before verifying operation.";

        sw = rw;
        mementries = 648;
        memwidth = 32;
    } MLDSA_PUBKEY;
    
    /* ---- MLDSA Component Signature ---- */
    external mem {
        name = "MLDSA component signature register type definition";
        desc = "1157 32-bit registers storing the signature of the message. 
                These registers are read by MLDSA user after signing operation, 
                or set before verifying operation.";

        sw = rw;
        mementries = 1157;
        memwidth = 32;
    } MLDSA_SIGNATURE;

    /* ---- MLDSA Component Private Key OUT---- */
    external mem {
        name = "MLDSA component private key output register type definition";
        desc = "1224 32-bit registers storing the private key for keygen.
                These registers are read by MLDSA user after keygen operation.";

        sw = r;
        mementries = 1224;
        memwidth = 32;
    } MLDSA_PRIVKEY_OUT;

    /* ---- MLDSA Component Private Key IN---- */
    external mem {
        name = "MLDSA component private key input register type definition";
        desc = "1224 32-bit entries storing the private key for signing. 
                These entries must be set before signing operation.";

        sw = w;
        mementries = 1224;
        memwidth = 32;
    } MLDSA_PRIVKEY_IN;

    //Don't move these - breaks backwards compatibility with Caliptra
    kv_read_ctrl_reg kv_mldsa_seed_rd_ctrl @0x8000;
    kv_status_reg kv_mldsa_seed_rd_status;

    /* ---- MLKEM Component Name ---- */
    reg {
        name = "MLKEM component name register type definition";
        desc = "Two 32-bit read-only registers representing of the name
                of MLKEM component.";

        default sw = r;
        default hw = w;
        field {desc = "Name field";} NAME[32];

    } MLKEM_NAME[2] @0x9000;

    /* ---- MLKEM Component Version ---- */
    reg {
        name = "MLKEM component version register type definition";
        desc = "Two 32-bit read-only registers representing of the version
                of MLKEM component.";

        default sw = r;
        default hw = w;
        field {desc = "Version field";} VERSION[32];
        
    } MLKEM_VERSION[2];

    /* ---- MLKEM Component Control ---- */
    reg {
        name = "MLKEM component control register type definition";
        desc = "Control register to set the type of MLKEM operations.";

        default sw = w;
        default hw = r;
        default resetsignal = reset_b;
        field {desc = "Control command field. This can be: 
                [br]            000 for NONE
                [br]            001 for KEYGEN
                [br]            010 for ENCAPS
                [br]            011 for DECAPS
                [br]            100 for KEYGEN+DECAPS
                
                [br] After each software write, hardware will erase the register"; swwe = abr_ready; hwclr;} CTRL[3] = 3'b0;

        field {desc = "Zeroize all internal registers: Zeroize all internal registers and memories to avoid SCA leakage.
                       [br] Software write generates only a single-cycle pulse on the 
                       [br] hardware interface and then will be erased"; singlepulse;} ZEROIZE = 1'b0;
    
    } MLKEM_CTRL;

    /* ---- MLKEM Component Status ---- */
    reg {
        name = "MLKEM component status register type definition";
        desc = "One 3-bit register including the following flags: 
                [br]bit #0: READY : ​Indicates if the core is ready to take
                [br]                a control command and process the inputs.  
                [br]bit #1: VALID : ​Indicates if the process is done and the
                [br]                result is valid.  
                [br]bit #2: ERROR : ​Indicates the process ended in an error. 
                ";

        default sw = r;
        default hw = w;
        default resetsignal = reset_b;
        field {desc = "Status ready bit";} READY = 1'b0;
        field {hw = rw; desc = "Status valid bit";} VALID = 1'b0;
        field {hw = rw; desc = "Status error bit";} ERROR = 1'b0;
    
    } MLKEM_STATUS;
    
    /* ---- MLKEM Component Input SEED ---- */
    reg {
        name = "MLKEM component seed register type definition";
        desc = "8 32-bit registers storing the 256-bit seed for keygen.
                The seed can be any 256-bit value in [0 : 2^256-1].";

        default sw = w;
        default hw = rw;
        default we = true;
        default resetsignal = reset_b;
        field {desc = "Input seed d field"; swwe; hwclr;} SEED[32] = 32'b0;
    
    } MLKEM_SEED_D[8];

    /* ---- MLKEM Component Input SEED ---- */
    external reg {
        name = "MLKEM component seed register type definition";
        desc = "8 32-bit registers storing the 256-bit seed for keygen.
                The seed can be any 256-bit value in [0 : 2^256-1].";

        default sw = w;
        default hw = rw;
        default we = true;
        default resetsignal = reset_b;
        field {desc = "Input seed z field"; swwe; hwclr;} SEED[32] = 32'b0;
    
    } MLKEM_SEED_Z[8];

    /* ---- MLKEM Component Shared Key ---- */
    external reg {
        name = "MLKEM component shared key register type definition";
        desc = "8 32-bit registers storing the shared key.";

        default sw = r;
        default hw = rw;
        default we = true;
        default resetsignal = reset_b;
        field {desc = "Output shared key"; hwclr;} KEY[32] = 32'b0;
    
    } MLKEM_SHARED_KEY[8];

    /* ---- MLKEM Component Input Message ---- */
    external mem {
        name = "MLKEM component message register type definition";
        desc = "256-bit message. The message can be a fixed size of 256-bit value in [0 : 2^256-1].
                [br]The message is written only through this register interface; it cannot be sourced from the key vault.";
        
        sw = rw;
        mementries = 8;
        memwidth = 32;
    } MLKEM_MSG;

    /* ---- MLKEM Component Decaps Key ---- */
    external mem {
        name = "MLKEM component decaps key register type definition";
        desc = "3,168 byte decapsulation key";

        sw = rw;
        mementries = 792;
        memwidth = 32;
    } MLKEM_DECAPS_KEY;

    /* ---- MLKEM Component Encaps Key ---- */
    external mem {
        name = "MLKEM component encaps key register type definition";
        desc = "1,568 byte encapsulation key";

        sw = rw;
        mementries = 392;
        memwidth = 32;
    } MLKEM_ENCAPS_KEY;

    /* ---- MLKEM Component Ciphertext ---- */
    external mem {
        name = "MLKEM component ciphertext register type definition";
        desc = "1,568 byte ciphertext";

        sw = rw;
        mementries = 392;
        memwidth = 32;
    } MLKEM_CIPHERTEXT;

    //Moved down to dedicated space to keep room above for any future enhancements
    kv_read_ctrl_reg kv_mlkem_seed_rd_ctrl @0xC000;
    kv_status_reg kv_mlkem_seed_rd_status;
    // 0xC008-0xC00F reserved: ENCAPS message is API-only and cannot be sourced from the key vault
    kv_write_ctrl_reg kv_mlkem_sharedkey_wr_ctrl @0xC010;
    kv_status_reg kv_mlkem_sharedkey_wr_status;


    ////////////////////////////////////////////////////////////////
    // Interrupts
    /* -----------------------
     * Register File definitive definition
     * ----------------------- */

    // Notifications are non-error events that occur during normal operation of the module.
    // E.g. a completion of a job may produce a notification.
    // Error and notification events are separated into separate status/trigger registers
    // to allow effective priority allocation by software
    regfile intr_block_t {


        /* -----------------------
         * Default properties for Register File
         * ----------------------- */

        name = "Interrupt Register Block";
        desc = "Set of registers to implement interrupt functionality for ABR";

        default regwidth = 32; // reg property
        default accesswidth = 32; // reg property
        default hw = na; // field property


        /* -----------------------
         * Register definitive definitions
         * ----------------------- */

        /* ---- Global Interrupt Enable ---- */
        reg global_intr_en_t {
            name = "Per-Type Interrupt Enable Register";
            desc = "Dedicated register with one bit for each event type that may produce an interrupt.";

            default hw = na;
            default sw = rw;

            // Global enablement (for interrupts of the event types defined for this module)
            field {desc = "Global enable bit for all events of type 'Error'";       } error_en = 1'b0;
            field {desc = "Global enable bit for all events of type 'Notification'";} notif_en = 1'b0;
        };

        /* ---- Error Interrupt Enable ---- */
        reg error_intr_en_t {
            name = "Per-Event Interrupt Enable Register";
            desc = "Dedicated register with one bit for each event that may produce an interrupt.";

            default hw = na;
            default sw = rw;

            // Specific enables for the events defined in this
            // event type in the instantiating peripheral.
            field {desc = "Enable bit for Internal Errors";               } error_internal_en = 1'b0;
        };

        /* ---- Notification Interrupt Enable ---- */
        reg notif_intr_en_t {
            name = "Per-Event Interrupt Enable Register";
            desc = "Dedicated register with one bit for each event that may produce an interrupt.";

            default hw = na;
            default sw = rw;

            // Specific enables for the events defined in this
            // event type in the instantiating peripheral.
            field {desc = "Enable bit for Command Done";} notif_cmd_done_en = 1'b0;
        };

        /* ---- Error Interrupt Status ---- */
        reg error_intr_t {
            name = "Interrupt Status Register type definition";
            desc = "Single bit indicating occurrence of each interrupt event.
                    Sticky, level assertion, write-1-to-clear.";

            default precedence = hw;
            default hw = w;
            default hwset = true;
            default sw = rw;
            default woclr = true;
            default level intr;

            field {desc = "Internal Errors status bit";                 } error_internal_sts = 1'b0;
        };

        /* ---- Notification Interrupt Status ---- */
        reg notif_intr_t {
            name = "Interrupt Status Register type definition";
            desc = "Single bit indicating occurrence of each interrupt event.
                    Sticky, level assertion, write-1-to-clear.";

            default precedence = hw;
            default hw = w;
            default hwset = true;
            default sw = rw;
            default woclr = true;
            default level intr;

            field {desc = "Command Done status bit";} notif_cmd_done_sts = 1'b0;
        };

        /* ---- Aggregated Interrupt Status ---- */
        reg global_intr_t {
            name = "Interrupt Status Aggregation Register type definition";
            desc = "Single bit indicating occurrence of any interrupt event
                    of a given type. E.g. Notifications and Errors may drive
                    to two separate interrupt registers. There may be
                    multiple sources of Notifications or Errors that are
                    aggregated into a single interrupt pin for that
                    respective type. That pin feeds through this register
                    in order to apply a global enablement of that interrupt
                    event type.
                    Nonsticky assertion.";

            default hw = w;
            default sw = r;
            default nonsticky intr;

            field {desc = "Interrupt Event Aggregation status bit";} agg_sts = 1'b0;
        };

        /* ---- Error Interrupt Trigger ---- */
        reg error_intr_trig_t {
            name = "Interrupt Trigger Register type definition";
            desc = "Single bit for each interrupt event allows SW to manually
                    trigger occurrence of that event. Upon SW write, the trigger bit
                    will pulse for 1 cycle then clear to 0. The pulse on the
                    trigger register bit results in the corresponding interrupt
                    status bit being set to 1.";

            default hw = na;
            default sw = rw;
            default woset = true;
            default singlepulse = true;

            // Instantiate triggers bit-by-bit.
            field {desc = "Internal Errors trigger bit";               } error_internal_trig = 1'b0;
        };

        /* ---- Notification Interrupt Trigger ---- */
        reg notif_intr_trig_t {
            name = "Interrupt Trigger Register type definition";
            desc = "Single bit for each interrupt event allows SW to manually
                    trigger occurrence of that event. Upon SW write, the trigger bit
                    will pulse for 1 cycle then clear to 0. The pulse on the
                    trigger register bit results in the corresponding interrupt
                    status bit being set to 1.";

            default hw = na;
            default sw = rw;
            default woset = true;
            default singlepulse = true;

            // Instantiate triggers bit-by-bit.
            field {desc = "Command Done trigger bit";} notif_cmd_done_trig = 1'b0;
        };

        /* ---- Interrupt Statistics Counter Incrementor ---- */
        reg intr_count_incr_t {
            name = "Interrupt Event Count Incrementor";
            desc = "Trigger the event counter to increment based on observing
                    the rising edge of an interrupt event input from the
                    Hardware. The same input signal that causes an interrupt
                    event to be set (sticky) also causes this signal to pulse
                    for 1 clock cycle, resulting in the event counter
                    incrementing by 1 for every interrupt event.
                    This is implemented as a down-counter (1-bit) that will
                    decrement immediately on being set - resulting in a pulse";

            default hw = w;
            default sw = r; // Has to have some access.... ideally SW wouldn't even see this
            default hwset = true;
            default decrvalue = 1;
            default counter;

            field {desc = "Pulse mirrors interrupt event occurrence";} pulse = 1'b0;
        };

        /* ---- Interrupt Statistics Counter ---- */
        reg intr_count_t {
            name = "Interrupt Event Counter";
            desc = "Provides statistics about the number of events that have
                    occurred.
                    Will not overflow ('incrsaturate').";

            default sw = rw;
            default hw = na;
            default incrvalue = 1;
            default incrsaturate = true;
            default counter;

            field {desc = "Count field";} cnt[32] = 32'h0;
        };


        /* ------------------------------------------------- Registers ------------------------------------------------- */
        // First 9 registers are static and always defined                                                               //
        global_intr_en_t  global_intr_en_r;      /* 1-bit per event type */                                              //
        error_intr_en_t   error_intr_en_r;       /* 1-bit per error */                                                   //
        notif_intr_en_t   notif_intr_en_r;       /* 1-bit per notification */                                            //
        global_intr_t     error_global_intr_r;   /* 1-bit aggregating all error interrupts with global enable */         //
        global_intr_t     notif_global_intr_r;   /* 1-bit aggregating all notification interrupts with global enable */  //
        error_intr_t      error_internal_intr_r; /* Error pending, SW write 1 to clear */                                //
        notif_intr_t      notif_internal_intr_r; /* Notification pending, SW write 1 to clear */                         //
        error_intr_trig_t error_intr_trig_r;     /* SW sets error bit for interrupt testing */                           //
        notif_intr_trig_t notif_intr_trig_r;     /* SW sets notification bit for interrupt testing */                    //
                                                                                                                         //
        // Align this set of registers; number of counters is based on peripheral event requirements                     //
        intr_count_t      error_internal_intr_count_r @0x100;  /* Per error */                                           //
        intr_count_t      notif_cmd_done_intr_count_r @0x180; /* Per notification */                                     //
                                                                                                                         //
        // These registers should be treated by SW as reserved, and ignored.                                             //
        // Offset at 0x200 gives enough space for 32 Errors and 32 Notifications                                         //
        // to be implemented (requiring 2*32 32-bit registers starting at                                                //
        // offset 0x100), and still allowing the entire regfile to fit                                                   //
        // inside a 1024-byte space.                                                                                     //
        intr_count_incr_t error_internal_intr_count_incr_r @0x200; /* Per error count incrementor pulse */               //
        intr_count_incr_t notif_cmd_done_intr_count_incr_r;       /* Per notification count incrementor pulse */         //
        /* ------------------------------------------------------------------------------------------------------------- */

        /* ---- Reset assignment for Error Events ---- */
        error_internal_intr_r.error_internal_sts -> resetsignal = hard_reset_b;
        error_internal_intr_count_r.cnt          -> resetsignal = hard_reset_b;

        /* ---- Interrupt Event Dynamic Assignments ---- */
        error_internal_intr_r.error_internal_sts -> enable = error_intr_en_r.error_internal_en;
        notif_internal_intr_r.notif_cmd_done_sts -> enable = notif_intr_en_r.notif_cmd_done_en;

        error_internal_intr_r.error_internal_sts -> next   = error_intr_trig_r.error_internal_trig;
        notif_internal_intr_r.notif_cmd_done_sts -> next   = notif_intr_trig_r.notif_cmd_done_trig;

        // NOTE: hwset for events is implicitly defined as module input

        /* ---- Global Interrupt Dynamic Assignments ---- */
        error_global_intr_r.agg_sts -> enable = global_intr_en_r.error_en;
        notif_global_intr_r.agg_sts -> enable = global_intr_en_r.notif_en;

        error_global_intr_r.agg_sts -> next = error_internal_intr_r -> intr;
        notif_global_intr_r.agg_sts -> next = notif_internal_intr_r -> intr;

        /* ---- Event Statistics Tracker Assignments ---- */
        // NOTE: This method relies upon a "counter" that is set using the
        //       same events that trigger an interrupt, then immediately
        //       self-clearing, which results in a pulse. Must be configured
        //       to be sensitive to the interrupt trigger events for each event.
        //       The output pulse is then used to increment the ACTUAL counter
        error_internal_intr_count_incr_r.pulse -> hwset    = error_internal_intr_r.error_internal_sts -> hwset; // \_____ Capture both firmware and hardware triggered events
        error_internal_intr_count_incr_r.pulse -> next     = error_internal_intr_r.error_internal_sts -> next;  // /      as a pulse to increment the intr_count_r register
        error_internal_intr_count_incr_r.pulse -> we       = error_internal_intr_r.error_internal_sts -> next;  // Generate a pulse from SW trigger, if set, or default to use the hwset input
        error_internal_intr_count_incr_r.pulse -> decr     = error_internal_intr_count_incr_r.pulse; // Auto-clear to generate pulse output
        error_internal_intr_count_r.cnt        -> incr     = error_internal_intr_count_incr_r.pulse; // Increment coincides with rising edge of interrupt sts bit

        notif_cmd_done_intr_count_incr_r.pulse -> hwset    = notif_internal_intr_r.notif_cmd_done_sts -> hwset; // \_____ Capture both firmware and hardware triggered events
        notif_cmd_done_intr_count_incr_r.pulse -> next     = notif_internal_intr_r.notif_cmd_done_sts -> next;  // /      as a pulse to increment the intr_count_r register
        notif_cmd_done_intr_count_incr_r.pulse -> we       = notif_internal_intr_r.notif_cmd_done_sts -> next;  // Generate a pulse from SW trigger, if set, or default to use the hwset input
        notif_cmd_done_intr_count_incr_r.pulse -> decr     = notif_cmd_done_intr_count_incr_r.pulse; // Auto-clear to generate pulse output
        notif_cmd_done_intr_count_r.cnt        -> incr     = notif_cmd_done_intr_count_incr_r.pulse; // Increment coincides with rising edge of interrupt sts bit

    };

    /* -----------------------
     * Register File instance
     * ----------------------- */
    //Don't move these - breaks backwards compatibility with Caliptra
    intr_block_t intr_block_rf @0x8100;
};
